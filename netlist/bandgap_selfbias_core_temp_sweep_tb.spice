** sch_path: /foss/designs/test/testbench/bandgap_selfbias_core_temp_sweep_tb.sch
**.subckt bandgap_selfbias_core_temp_sweep_tb
VGD gd 0 0
VP vp gd xvp
.save i(vp)
VSUB gd sub! 0
C1 v_ref gd 1p
x1 vp v_ref gd vd bandgap_selfbias_core
XQ1 gd gd vd pnpMPA a=1e-12 p=4e-06 m=4
**** begin user architecture code

.lib cornerMOSlv.lib mos_tt
.lib cornerPNP.lib typ

.param xvp=1.2

.param xtemp=25

.probe isub(x1)
.save v(v_ref)
.save v(vp)
.save v(vd)
.save v(start_up)
.save i(vp)
.save i(vibias)
*.save all

*.options rshunt=1G

.temp 'xtemp'
.dc temp -50 125 0.1

**** end user architecture code
**.ends

* expanding   symbol:  /foss/designs/test/circuit/bandgap_selfbias_core.sym # of pins=4
** sym_path: /foss/designs/test/circuit/bandgap_selfbias_core.sym
** sch_path: /foss/designs/test/circuit/bandgap_selfbias_core.sch
.subckt bandgap_selfbias_core vp vref gd diode
*.opin diode
*.ipin gd
*.ipin vp
*.opin vref
XM12 diode net4 vp vp sg13_lv_pmos w=1.2u l=0.9u ng=1 m=8
XM3 net4 diode net2 gd sg13_lv_nmos w=1.2u l=0.9u ng=1 m=40
XM1 net1 net1 gd gd sg13_lv_nmos w=1.2u l=0.9u ng=1 m=8
XM2 net2 diode net1 gd sg13_lv_nmos w=1.2u l=0.9u ng=1 m=8
XM4 net4 net4 vp vp sg13_lv_pmos w=1.2u l=0.9u ng=1 m=2
XM5 net5 net3 net2 gd sg13_lv_nmos w=1.2u l=0.9u ng=1 m=2
XM6 net3 net3 net5 gd sg13_lv_nmos w=1.2u l=0.9u ng=1 m=8
XM7 net3 net4 vp vp sg13_lv_pmos w=1.2u l=0.9u ng=1 m=2
XM8 vref net6 net5 gd sg13_lv_nmos w=1.2u l=0.9u ng=1 m=2
XM9 net6 net6 vref gd sg13_lv_nmos w=1.2u l=0.9u ng=1 m=8
XM10 net6 net4 vp vp sg13_lv_pmos w=1.2u l=0.9u ng=1 m=2
XM11 vref net4 vp vp sg13_lv_pmos w=1.2u l=0.9u ng=1 m=4
.ends

.GLOBAL sub!
.end
