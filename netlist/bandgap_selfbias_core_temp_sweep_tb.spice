** sch_path: /foss/designs/test/testbench/bandgap_selfbias_core_temp_sweep_tb.sch
**.subckt bandgap_selfbias_core_temp_sweep_tb
VGD gd 0 0
VP vp gd xvp
.save i(vp)
VSUB gd sub! 0
C1 v_ref gd 1p
x1 vp v_ref gd bandgap_selfbias_core
**** begin user architecture code

.lib cornerMOShv.lib mos_tt
.lib cornerPNP.lib typ

.param xvp=1.2

.param xtemp=25

.probe isub(x1)
.save v(v_ref)
.save v(vp)
.save v(vd)
.save v(start_up)
.save i(vp)
.save i(vibias)
*.save all

*.options rshunt=1G

.temp 'xtemp'
.dc temp -50 125 0.1

**** end user architecture code
**.ends

* expanding   symbol:  /foss/designs/test/circuit/bandgap_selfbias_core.sym # of pins=3
** sym_path: /foss/designs/test/circuit/bandgap_selfbias_core.sym
** sch_path: /foss/designs/test/circuit/bandgap_selfbias_core.sch
.subckt bandgap_selfbias_core vp vref gd
*.ipin gd
*.ipin vp
*.opin vref
XM1 net1 net1 gd gd sg13_hv_nmos w=1.2u l=0.9u ng=1 m=2
XM2 net4 net1 net5 gd sg13_hv_nmos w=1.2u l=0.9u ng=1 m=8
XM7 net5 vref gd gd sg13_hv_nmos w=1.2u l=0.9u ng=1 m=4
XM3 net2 net2 net1 gd sg13_hv_nmos w=1.2u l=0.9u ng=1 m=2
XM4 net3 net2 net4 gd sg13_hv_nmos w=1.2u l=0.9u ng=1 m=8
XM6 net3 net3 vp vp sg13_hv_pmos w=1.2u l=0.9u ng=1 m=2
XM5 net2 net3 vp vp sg13_hv_pmos w=1.2u l=0.9u ng=1 m=2
XM10 net6 net3 vp vp sg13_hv_pmos w=1.2u l=0.9u ng=1 m=2
XM8 net7 net6 gd gd sg13_hv_nmos w=1.2u l=0.9u ng=1 m=20
XM9 net6 net6 net7 gd sg13_hv_nmos w=1.2u l=0.9u ng=1 m=12
XM13 net8 net3 vp vp sg13_hv_pmos w=1.2u l=0.9u ng=1 m=2
XM11 net9 net8 net7 gd sg13_hv_nmos w=1.2u l=0.9u ng=1 m=20
XM12 net8 net8 net9 gd sg13_hv_nmos w=1.2u l=0.9u ng=1 m=10
XM14 vref vref net9 gd sg13_hv_nmos w=1.2u l=0.9u ng=1 m=8
XM15 vref net3 vp vp sg13_hv_pmos w=1.2u l=0.9u ng=1 m=2
.ends

.GLOBAL sub!
.end
