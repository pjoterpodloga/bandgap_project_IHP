** sch_path: /foss/designs/test/testbench/bandgap_res_temp_sweep_tb.sch
**.subckt bandgap_res_temp_sweep_tb
VGD gd 0 0
VP vp gd xvp
.save i(vp)
VSUB gd sub! 0
C1 v_ref gd 1p
x2 vd1 vd8 gd bandgap_res_diodes
xdut vp v_ref gd vd8 vd1 vbias bandgap_res_core_wrapper
* noconn vbias
**** begin user architecture code

.lib cornerMOShv.lib mos_tt
.lib cornerRES.lib res_typ
.lib cornerPNP.lib typ

.param xvp=3.3

.param xtemp=25

.probe isub(x1)
.save v(v_ref)
.save v(vp)
.save v(start_up)
.save v(x1.vg)
.save v(vd1)
.save v(vd8)
.save i(vp)
.save v(vbias)

.options rshunt=1G

.temp 'xtemp'
.dc temp -50 125 0.1

**** end user architecture code
**.ends

* expanding   symbol:  /foss/designs/test/circuit/bandgap_res_diodes.sym # of pins=3
** sym_path: /foss/designs/test/circuit/bandgap_res_diodes.sym
** sch_path: /foss/designs/test/circuit/bandgap_res_diodes.sch
.subckt bandgap_res_diodes d1 d8 gd
*.ipin gd
*.ipin d1
*.ipin d8
XQ1 gd gd d1 pnpMPA a=4e-12 p=8e-06
XQ2 gd gd d8 pnpMPA a=4e-12 p=8e-06 m=8
.ends

* expanding   symbol:  /foss/designs/test/circuit/bandgap_res_core_wrapper.sym # of pins=6
** sym_path: /foss/designs/test/circuit/bandgap_res_core_wrapper.sym
** sch_path: /foss/designs/test/circuit/bandgap_res_core_wrapper.sch
.subckt bandgap_res_core_wrapper vp vref gd d8 d1 vbias
*.ipin vp
*.ipin gd
*.opin vref
*.opin d1
*.opin d8
*.opin vbias
xbandgap vp vbias vref gd d8 d1 bandgap_res_core
xbias vp vbias gd pbias nbias const_gm_bias
* noconn nbias
* noconn pbias
.ends

* expanding   symbol:  /foss/designs/test/circuit/bandgap_res_core.sym # of pins=6
** sym_path: /foss/designs/test/circuit/bandgap_res_core.sym
** sch_path: /foss/designs/test/circuit/bandgap_res_core.sch
.subckt bandgap_res_core vp ibias vref gd d8 d1
*.ipin gd
*.ipin vp
*.ipin ibias
*.opin vref
*.opin d1
*.opin d8
XM2 net1 vg vp vp sg13_hv_pmos w=3.6u l=0.9u ng=1 m=10
XM1 d1 vg vp vp sg13_hv_pmos w=3.6u l=0.9u ng=1 m=10
XM3 vref vg vp vp sg13_hv_pmos w=3.6u l=0.9u ng=1 m=10
XR2 net1 gd gd rppd w=2e-6 l=111.6e-6 m=1 b=0
XR3 d1 gd gd rppd w=2e-6 l=111.6e-6 m=1 b=0
XR4 vref gd gd rppd w=2e-6 l=111.6e-6 m=1 b=0
XR1 net1 d8 gd rppd w=5.8e-6 l=45.5e-6 m=1 b=0
XR5 gd net2 gd rppd w=2e-6 l=41.85e-6 m=1 b=0
XR6 net2 gd gd rppd w=2e-6 l=13.95e-6 m=1 b=0
XR7 gd gd gd rppd w=2e-6 l=13.95e-6 m=2 b=0
x1 vp net1 d1 vg ibias gd opamp_folded_pmos
.ends

* expanding   symbol:  /foss/designs/test/circuit/const_gm_bias.sym # of pins=5
** sym_path: /foss/designs/test/circuit/const_gm_bias.sym
** sch_path: /foss/designs/test/circuit/const_gm_bias.sch
.subckt const_gm_bias vp ibias gd pbias nbias
*.opin ibias
*.ipin vp
*.ipin gd
*.opin pbias
*.opin nbias
xgm_core vp ibias gd vr pbias nbias const_gm_bias_core
XRbias vr gd gd rppd w=1.2e-6 l=11.7e-6 m=1 b=0
XR2 gd net1 gd rppd w=1.2e-6 l=3.9e-6 m=1 b=0
XR3 net1 gd gd rppd w=1.2e-6 l=1.3e-6 m=1 b=0
.ends

* expanding   symbol:  /foss/designs/test/circuit/opamp_folded_pmos.sym # of pins=6
** sym_path: /foss/designs/test/circuit/opamp_folded_pmos.sym
** sch_path: /foss/designs/test/circuit/opamp_folded_pmos.sch
.subckt opamp_folded_pmos vp inp inm out ibias gd
*.ipin ibias
*.ipin inp
*.ipin inm
*.opin out
*.ipin gd
*.ipin vp
XM13 bias4 ibias gd gd sg13_hv_nmos w=1.2u l=0.9u ng=1 m=2
XM12 ibias ibias gd gd sg13_hv_nmos w=1.2u l=0.9u ng=1 m=2
XM14 bias4 bias4 vp vp sg13_hv_pmos w=3.6u l=0.9u ng=1 m=2
XM11 pair_com bias4 vp vp sg13_hv_pmos w=3.6u l=0.9u ng=1 m=4
XM1 inp_fold inp pair_com vp sg13_hv_pmos w=2.4u l=0.9u ng=1 m=12
XM2 inm_fold inm pair_com vp sg13_hv_pmos w=2.4u l=0.9u ng=1 m=12
XM9 tele_m tele_g vp vp sg13_hv_pmos w=3.6u l=0.9u ng=1 m=2
XM10 tele_p tele_g vp vp sg13_hv_pmos w=3.6u l=0.9u ng=1 m=2
XM7 tele_g bias3 tele_m vp sg13_hv_pmos w=3.6u l=0.9u ng=1 m=2
XM8 out bias3 tele_p vp sg13_hv_pmos w=3.6u l=0.9u ng=1 m=2
XM3 inp_fold ibias gd gd sg13_hv_nmos w=1.2u l=0.9u ng=1 m=4
XM4 inm_fold ibias gd gd sg13_hv_nmos w=1.2u l=0.9u ng=1 m=4
XM5 tele_g bias2 inp_fold gd sg13_hv_nmos w=1.2u l=0.9u ng=1 m=2
XM6 out bias2 inm_fold gd sg13_hv_nmos w=1.2u l=0.9u ng=1 m=2
XM15 bias3 ibias gd gd sg13_hv_nmos w=1.2u l=0.9u ng=1 m=4
XM16 bias3 bias3 net1 vp sg13_hv_pmos w=3.6u l=0.9u ng=1
XM17 net1 bias3 vp vp sg13_hv_pmos w=3.6u l=0.9u ng=1
XM20 bias2 bias4 vp vp sg13_hv_pmos w=3.6u l=0.9u ng=1 m=4
XM18 net2 bias2 gd gd sg13_hv_nmos w=1.2u l=0.9u ng=1
XM19 bias2 bias2 net2 gd sg13_hv_nmos w=1.2u l=0.9u ng=1
XM21 bias2 gd gd gd sg13_hv_nmos w=1.2u l=0.9u ng=1
XM22 pair_com vp vp vp sg13_hv_pmos w=2.4u l=0.9u ng=1 m=2
XM23 bias3 vp vp vp sg13_hv_pmos w=3.6u l=0.9u ng=1
.ends

* expanding   symbol:  /foss/designs/test/circuit/const_gm_bias_core.sym # of pins=6
** sym_path: /foss/designs/test/circuit/const_gm_bias_core.sym
** sch_path: /foss/designs/test/circuit/const_gm_bias_core.sch
.subckt const_gm_bias_core vp ibias gd res pbias nbias
*.ipin vp
*.ipin gd
*.opin ibias
*.opin res
*.opin nbias
*.opin pbias
XM1 net1 nbias gd gd sg13_hv_nmos w=0.6u l=2u ng=1 m=2
XM3 net2 nbias res gd sg13_hv_nmos w=0.6u l=2u ng=1 m=4
XM8 net5 pbias vp vp sg13_hv_pmos w=0.6u l=2u ng=1 m=2
XM6 net4 pbias vp vp sg13_hv_pmos w=0.6u l=2u ng=1 m=2
XM12 net3 pbias vp vp sg13_hv_pmos w=0.6u l=2u ng=1
XM15 net6 gd vp vp sg13_hv_pmos w=0.6u l=4.38u ng=1
XM13 stup nbias gd gd sg13_hv_nmos w=0.6u l=2u ng=1 m=4
XM16 pbias stup gd gd sg13_hv_nmos w=0.6u l=2u ng=1 m=2
XM2 nbias nbias net1 gd sg13_hv_nmos w=0.6u l=2u ng=1 m=2
XM4 pbias nbias net2 gd sg13_hv_nmos w=0.6u l=2u ng=1 m=4
XM11 net8 pbias net3 vp sg13_hv_pmos w=0.6u l=2u ng=1
XM7 pbias pbias net5 vp sg13_hv_pmos w=0.6u l=2u ng=1 m=2
XM5 nbias pbias net4 vp sg13_hv_pmos w=0.6u l=2u ng=1 m=2
XM14 stup gd net6 vp sg13_hv_pmos w=0.6u l=4.38u ng=1
XM10 net7 pbias net8 vp sg13_hv_pmos w=0.6u l=2u ng=1
XM9 ibias pbias net7 vp sg13_hv_pmos w=0.6u l=2u ng=1
.ends

.GLOBAL sub!
.end
