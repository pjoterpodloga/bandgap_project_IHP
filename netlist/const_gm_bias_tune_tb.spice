** sch_path: /foss/designs/test/testbench/const_gm_bias_tune_tb.sch
**.subckt const_gm_bias_tune_tb
x1 vp out gd res const_gm_bias_core
VP vp gd 'xvp'
.save i(vp)
VGD gd 0 0
VSUB gd sub! 0
Vres res gd 0
.save i(vres)
Vibias out gd 0
.save i(vibias)
**** begin user architecture code

.LIB cornerMOShv.lib mos_tt
.LIB cornerRES.lib res_typ
.LIB cornerPNP.lib typ
.SAVE i(vibias)
.SAVE i(vres)
.PARAM xvp=3.3
.PARAM xtemp=25
.PROBE v(res)
.PROBE v(out)
.GLOBAL sub!
.TEMP 'xtemp'
.DC vres 0 1.2 0.001

**** end user architecture code
**.ends

* expanding   symbol:  /foss/designs/test/circuit/const_gm_bias_core.sym # of pins=4
** sym_path: /foss/designs/test/circuit/const_gm_bias_core.sym
** sch_path: /foss/designs/test/circuit/const_gm_bias_core.sch
.subckt const_gm_bias_core vp ibias gd res
*.ipin vp
*.ipin gd
*.opin ibias
*.opin res
XM1 nbias nbias gd gd sg13_hv_nmos w=0.6u l=2u ng=1 m=2
XM2 pbias nbias res gd sg13_hv_nmos w=0.6u l=2u ng=1 m=4
XM4 pbias pbias vp vp sg13_hv_pmos w=0.6u l=2u ng=1 m=2
XM3 nbias pbias vp vp sg13_hv_pmos w=0.6u l=2u ng=1 m=2
XM5 ibias pbias vp vp sg13_hv_pmos w=0.6u l=2u ng=1 m=2
XM7 stup gd vp vp sg13_hv_pmos w=0.6u l=4u ng=1
XM6 stup nbias gd gd sg13_hv_nmos w=0.6u l=2u ng=1 m=4
XM8 pbias stup gd gd sg13_hv_nmos w=0.6u l=2u ng=1 m=2
.ends

.end
