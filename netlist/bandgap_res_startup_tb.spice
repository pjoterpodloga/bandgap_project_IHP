** sch_path: /foss/designs/test/testbench/bandgap_res_startup_tb.sch
**.subckt bandgap_res_startup_tb
xdut vp out gd vd8 vd1 vbias bandgap_res_core_wrapper
x2 vd1 vd8 gd bandgap_res_diodes
VGD gd 0 0
VSUB gd sub! 0
VP vp gd PWL(0 0 'xdelay' 0 'xdelay+1n' 'xvp')
C1 out gd 1f
C2 vbias gd 1f
**** begin user architecture code

.lib cornerMOShv.lib mos_tt
.lib cornerRES.lib res_typ
.lib cornerPNP.lib typ

.include cap_mfringe.lib

.param xvp=3.3
.param xtemp=25
.param xdelay=200n

.save v(out)
.save v(vd1)
.save v(vd8)
.save v(vp)
.save v(vbias)

.save v(xdut.xstartup.vcap)
.save v(xdut.xbandgap.vg)
.save v(xdut.xbias.vr)
.save v(xdut.vcap)

.probe isub(x2.d1)
.probe isub(x2.d8)

.save v(xdut.bandgap_res_startup_0.vcap)
.save v(xdut.const_gm_bias_0.vr)
.save v(xdut.const_gm_bias_0.startup)

.temp 'xtemp'

.options rshunt=1G

.tran 1n 5.2u uic

**** end user architecture code
**.ends

* expanding   symbol:  /foss/designs/test/circuit/bandgap_res_core_wrapper.sym # of pins=6
** sym_path: /foss/designs/test/circuit/bandgap_res_core_wrapper.sym
** sch_path: /foss/designs/test/circuit/bandgap_res_core_wrapper.sch
.subckt bandgap_res_core_wrapper vp vref gd d8 d1 vbias
*.ipin vp
*.ipin gd
*.opin vref
*.opin d1
*.opin d8
*.opin vbias
xbandgap vp vbias vref gd d8 d1 bandgap_res_core
xbias vp vbias gd pbias nbias const_gm_bias
* noconn nbias
* noconn pbias
.ends

* expanding   symbol:  /foss/designs/test/circuit/bandgap_res_diodes.sym # of pins=3
** sym_path: /foss/designs/test/circuit/bandgap_res_diodes.sym
** sch_path: /foss/designs/test/circuit/bandgap_res_diodes.sch
.subckt bandgap_res_diodes d1 d8 gd
*.ipin gd
*.ipin d1
*.ipin d8
XQ1 gd gd d1 pnpMPA a=4e-12 p=8e-06
XQ2 gd gd d8 pnpMPA a=4e-12 p=8e-06 m=8
.ends

* expanding   symbol:  /foss/designs/test/circuit/bandgap_res_core.sym # of pins=6
** sym_path: /foss/designs/test/circuit/bandgap_res_core.sym
** sch_path: /foss/designs/test/circuit/bandgap_res_core.sch
.subckt bandgap_res_core vp ibias vref gd d8 d1
*.ipin gd
*.ipin vp
*.ipin ibias
*.opin vref
*.opin d1
*.opin d8
XM2 net1 vg vp vp sg13_hv_pmos w=3.6u l=0.9u ng=1 m=10
XM1 d1 vg vp vp sg13_hv_pmos w=3.6u l=0.9u ng=1 m=10
XM3 vref vg vp vp sg13_hv_pmos w=3.6u l=0.9u ng=1 m=10
XR2 net1 gd gd rppd w=2e-6 l=100e-6 m=1 b=0
XR3 d1 gd gd rppd w=2e-6 l=100e-6 m=1 b=0
XR4 vref gd gd rppd w=2e-6 l=100e-6 m=1 b=0
XR1 net1 d8 gd rppd w=5.8e-6 l=42e-6 m=1 b=0
xopamp vp net1 d1 vg ibias gd opamp_folded
XR5 gd net2 gd rppd w=2e-6 l=37.5e-6 m=1 b=0
XR6 net2 gd gd rppd w=2e-6 l=12.5e-6 m=1 b=0
XR7 gd gd gd rppd w=2e-6 l=12.5e-6 m=1 b=0
.ends

* expanding   symbol:  /foss/designs/test/circuit/const_gm_bias.sym # of pins=5
** sym_path: /foss/designs/test/circuit/const_gm_bias.sym
** sch_path: /foss/designs/test/circuit/const_gm_bias.sch
.subckt const_gm_bias vp ibias gd pbias nbias
*.opin ibias
*.ipin vp
*.ipin gd
*.opin pbias
*.opin nbias
xgm_core vp ibias gd vr pbias nbias const_gm_bias_core
XRbias vr gd gd rppd w=1.2e-6 l=11.7e-6 m=1 b=0
XR2 gd net1 gd rppd w=1.2e-6 l=3.9e-6 m=1 b=0
XR3 net1 gd gd rppd w=1.2e-6 l=1.3e-6 m=1 b=0
.ends

* expanding   symbol:  /foss/designs/test/circuit/opamp_folded.sym # of pins=6
** sym_path: /foss/designs/test/circuit/opamp_folded.sym
** sch_path: /foss/designs/test/circuit/opamp_folded.sch
.subckt opamp_folded vp inp inm out bias gd
*.ipin bias
*.opin out
*.ipin vp
*.ipin inp
*.ipin inm
*.ipin gd
XM1 inp_fold inp pair_com gd sg13_hv_nmos w=2.4u l=0.9u ng=1 m=10
XM2 inm_fold inm pair_com gd sg13_hv_nmos w=2.4u l=0.9u ng=1 m=10
XM3 tele_p tele_g gd gd sg13_hv_nmos w=1.2u l=0.9u ng=1 m=2
XM4 tele_m tele_g gd gd sg13_hv_nmos w=1.2u l=0.9u ng=1 m=2
XM5 tele_g bias2 tele_p gd sg13_hv_nmos w=1.2u l=0.9u ng=1 m=2
XM6 out bias2 tele_m gd sg13_hv_nmos w=1.2u l=0.9u ng=1 m=2
XM7 tele_g bias3 inp_fold vp sg13_hv_pmos w=3.6u l=0.9u ng=1 m=2
XM8 out bias3 inm_fold vp sg13_hv_pmos w=3.6u l=0.9u ng=1 m=2
XM9 inp_fold bias4 vp vp sg13_hv_pmos w=3.6u l=0.9u ng=1 m=4
XM10 inm_fold bias4 vp vp sg13_hv_pmos w=3.6u l=0.9u ng=1 m=4
XM11 pair_com bias gd gd sg13_hv_nmos w=1.2u l=0.9u ng=1 m=4
XM12 bias bias gd gd sg13_hv_nmos w=1.2u l=0.9u ng=1 m=2
XM13 bias4 bias gd gd sg13_hv_nmos w=1.2u l=0.9u ng=1 m=2
XM14 bias4 bias4 vp vp sg13_hv_pmos w=3.6u l=0.9u ng=1 m=2
XM15 bias3 bias gd gd sg13_hv_nmos w=1.2u l=0.9u ng=1 m=2
XM16 bias3 bias3 net2 vp sg13_hv_pmos w=3.6u l=0.9u ng=1
XM17 net2 bias3 vp vp sg13_hv_pmos w=3.6u l=0.9u ng=1
XM18 net1 bias2 gd gd sg13_hv_nmos w=1.2u l=0.9u ng=1
XM19 bias2 bias2 net1 gd sg13_hv_nmos w=1.2u l=0.9u ng=1
XM20 bias2 bias4 vp vp sg13_hv_pmos w=3.6u l=0.9u ng=1 m=4
XM21 pair_com gd gd gd sg13_hv_nmos w=2.4u l=0.9u ng=1 m=2
XM22 bias2 gd gd gd sg13_hv_nmos w=1.2u l=0.9u ng=1
XM23 vp vp bias3 vp sg13_hv_pmos w=3.6u l=0.9u ng=1
.ends

* expanding   symbol:  /foss/designs/test/circuit/const_gm_bias_core.sym # of pins=6
** sym_path: /foss/designs/test/circuit/const_gm_bias_core.sym
** sch_path: /foss/designs/test/circuit/const_gm_bias_core.sch
.subckt const_gm_bias_core vp ibias gd res pbias nbias
*.ipin vp
*.ipin gd
*.opin ibias
*.opin res
*.opin nbias
*.opin pbias
XM1 net1 nbias gd gd sg13_hv_nmos w=0.6u l=2u ng=1 m=2
XM3 net2 nbias res gd sg13_hv_nmos w=0.6u l=2u ng=1 m=4
XM8 net5 pbias vp vp sg13_hv_pmos w=0.6u l=2u ng=1 m=2
XM6 net4 pbias vp vp sg13_hv_pmos w=0.6u l=2u ng=1 m=2
XM12 net3 pbias vp vp sg13_hv_pmos w=0.6u l=2u ng=1
XM15 net6 gd vp vp sg13_hv_pmos w=0.6u l=4.38u ng=1
XM13 stup nbias gd gd sg13_hv_nmos w=0.6u l=2u ng=1 m=4
XM16 pbias stup gd gd sg13_hv_nmos w=0.6u l=2u ng=1 m=2
XM2 nbias nbias net1 gd sg13_hv_nmos w=0.6u l=2u ng=1 m=2
XM4 pbias nbias net2 gd sg13_hv_nmos w=0.6u l=2u ng=1 m=4
XM11 net8 pbias net3 vp sg13_hv_pmos w=0.6u l=2u ng=1
XM7 pbias pbias net5 vp sg13_hv_pmos w=0.6u l=2u ng=1 m=2
XM5 nbias pbias net4 vp sg13_hv_pmos w=0.6u l=2u ng=1 m=2
XM14 stup gd net6 vp sg13_hv_pmos w=0.6u l=4.38u ng=1
XM10 net7 pbias net8 vp sg13_hv_pmos w=0.6u l=2u ng=1
XM9 ibias pbias net7 vp sg13_hv_pmos w=0.6u l=2u ng=1
.ends

.GLOBAL sub!
.end
