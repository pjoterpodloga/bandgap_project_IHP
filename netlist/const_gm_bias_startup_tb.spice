** sch_path: /foss/designs/test/testbench/const_gm_bias_startup_tb.sch
**.subckt const_gm_bias_startup_tb
VP vp gd DC='xvp' PWL(0 0 'xdelay' 0 'xdelay+1n' 'xvp')
VGD gd 0 0
VSUB gd sub! 0
xdut vp ibias gd const_gm_bias
VIBIAS ibias gd 0
**** begin user architecture code

.lib cornerMOShv.lib mos_tt
.lib cornerRES.lib res_typ

.include cap_mfringe.lib

.param xvp=3.3
.param xtemp=25
.param xdelay=200n

.save v(ibias)
.save i(vibias)
.save v(nbias)

.save v(xdut.xgm_core.nbias)
.save v(xdut.xgm_core.pbias)
.save v(xdut.xgm_core.stup)

.save v(xdut.const_gm_bias_core_0.pbias)
.save v(xdut.const_gm_bias_core_0.nbias)
.save v(xdut.const_gm_bias_core_0.stup)

.save v(xdut.pbias)
.save v(xdut.nbias)
.save v(xdut.stup)

.temp 'xtemp'

.options rshunt=1G

.tran 500p 2.2u

**** end user architecture code
**.ends

* expanding   symbol:  /foss/designs/test/circuit/const_gm_bias.sym # of pins=3
** sym_path: /foss/designs/test/circuit/const_gm_bias.sym
** sch_path: /foss/designs/test/circuit/const_gm_bias.sch
.subckt const_gm_bias vp ibias gd
*.opin ibias
*.ipin vp
*.ipin gd
xgm_core vp ibias gd vr const_gm_bias_core
XRbias vr gd gd rppd w=1.2e-6 l=11.7e-6 m=1 b=0
XR2 gd net1 gd rppd w=1.2e-6 l=3.9e-6 m=1 b=0
XR3 net1 gd gd rppd w=1.2e-6 l=1.3e-6 m=1 b=0
.ends

* expanding   symbol:  /foss/designs/test/circuit/const_gm_bias_core.sym # of pins=4
** sym_path: /foss/designs/test/circuit/const_gm_bias_core.sym
** sch_path: /foss/designs/test/circuit/const_gm_bias_core.sch
.subckt const_gm_bias_core vp ibias gd res
*.ipin vp
*.ipin gd
*.opin ibias
*.opin res
XM1 nbias nbias gd gd sg13_hv_nmos w=0.6u l=2u ng=1 m=2
XM2 pbias nbias res gd sg13_hv_nmos w=0.6u l=2u ng=1 m=4
XM4 pbias pbias vp vp sg13_hv_pmos w=0.6u l=2u ng=1 m=2
XM3 nbias pbias vp vp sg13_hv_pmos w=0.6u l=2u ng=1 m=2
XM5 ibias pbias vp vp sg13_hv_pmos w=0.6u l=2u ng=1 m=2
XM7 stup gd vp vp sg13_hv_pmos w=0.6u l=4u ng=1
XM6 stup nbias gd gd sg13_hv_nmos w=0.6u l=2u ng=1 m=4
XM8 pbias stup gd gd sg13_hv_nmos w=0.6u l=2u ng=1 m=2
.ends

.GLOBAL sub!
.end
