** sch_path: /foss/designs/test/testbench/bandgap_bufor_dc_tb.sch
**.subckt bandgap_bufor_dc_tb
EINP inp net2 in gd 0.5
EINM inm net2 in gd -0.5
C1 out gd xcload
VGD gd 0 0
VP vp gd xvp
VSUB gd sub! 0
VIN in gd DC xvid
VCM net2 gd '0.7'
x2 vp net3 gd net4 net5 const_gm_bias
* noconn #net4
* noconn #net5
Viopamp vp net1 0
.save i(viopamp)
XM1 bias bias gd gd sg13_hv_nmos w=1.2u l=0.9u ng=1 m=2
x1 net1 inp inm out bias gd opamp_folded_pmos_buf
Vibias net3 bias 0
.save i(vibias)
**** begin user architecture code

.lib cornerMOShv.lib mos_tt
.lib cornerRES.lib res_typ

.param xvp=3.3
.param xvid=0
.param xcload=1p

.param xtemp=25

.save v(in)
.save v(out)
.save i(vibias)
.save v(vp)
.save i(viopamp)

.temp 'xtemp'
.dc VIN -10m 10m 10u

.option rshunt=1e12

**** end user architecture code
**.ends

* expanding   symbol:  /foss/designs/test/circuit/const_gm_bias.sym # of pins=5
** sym_path: /foss/designs/test/circuit/const_gm_bias.sym
** sch_path: /foss/designs/test/circuit/const_gm_bias.sch
.subckt const_gm_bias vp ibias gd pbias nbias
*.opin ibias
*.ipin vp
*.ipin gd
*.opin pbias
*.opin nbias
xgm_core vp ibias gd vr pbias nbias const_gm_bias_core
XRbias vr gd gd rppd w=1.2e-6 l=11.7e-6 m=1 b=0
XR2 gd net1 gd rppd w=1.2e-6 l=3.9e-6 m=1 b=0
XR3 net1 gd gd rppd w=1.2e-6 l=1.3e-6 m=1 b=0
.ends

* expanding   symbol:  /foss/designs/test/circuit/opamp_folded_pmos_buf.sym # of pins=6
** sym_path: /foss/designs/test/circuit/opamp_folded_pmos_buf.sym
** sch_path: /foss/designs/test/circuit/opamp_folded_pmos_buf.sch
.subckt opamp_folded_pmos_buf vp inp inm out vbias gd
*.ipin vbias
*.ipin inm
*.ipin inp
*.opin out
*.ipin gd
*.ipin vp
XM13 bias4 vbias gd gd sg13_hv_nmos w=1.2u l=0.9u ng=1 m=2
XM14 bias4 bias4 vp vp sg13_hv_pmos w=3.6u l=0.9u ng=1 m=2
XM11 pair_com bias4 vp vp sg13_hv_pmos w=3.6u l=0.9u ng=1 m=4
XM1 inp_fold inm pair_com vp sg13_hv_pmos w=2.4u l=0.9u ng=1 m=12
XM2 inm_fold inp pair_com vp sg13_hv_pmos w=2.4u l=0.9u ng=1 m=12
XM9 tele_m tele_g vp vp sg13_hv_pmos w=3.6u l=0.9u ng=1 m=2
XM10 tele_p tele_g vp vp sg13_hv_pmos w=3.6u l=0.9u ng=1 m=2
XM7 tele_g bias3 tele_m vp sg13_hv_pmos w=3.6u l=0.9u ng=1 m=2
XM8 net1 bias3 tele_p vp sg13_hv_pmos w=3.6u l=0.9u ng=1 m=2
XM3 inp_fold vbias gd gd sg13_hv_nmos w=1.2u l=0.9u ng=1 m=4
XM4 inm_fold vbias gd gd sg13_hv_nmos w=1.2u l=0.9u ng=1 m=4
XM5 tele_g bias2 inp_fold gd sg13_hv_nmos w=1.2u l=0.9u ng=1 m=2
XM6 net1 bias2 inm_fold gd sg13_hv_nmos w=1.2u l=0.9u ng=1 m=2
XM15 bias3 vbias gd gd sg13_hv_nmos w=1.2u l=0.9u ng=1 m=4
XM16 bias3 bias3 net2 vp sg13_hv_pmos w=3.6u l=0.9u ng=1
XM17 net2 bias3 vp vp sg13_hv_pmos w=3.6u l=0.9u ng=1
XM20 bias2 bias4 vp vp sg13_hv_pmos w=3.6u l=0.9u ng=1 m=4
XM18 net3 bias2 gd gd sg13_hv_nmos w=1.2u l=0.9u ng=1
XM19 bias2 bias2 net3 gd sg13_hv_nmos w=1.2u l=0.9u ng=1
XM21 bias2 gd gd gd sg13_hv_nmos w=1.2u l=0.9u ng=1
XM22 pair_com vp vp vp sg13_hv_pmos w=2.4u l=0.9u ng=1 m=2
XM23 bias3 vp vp vp sg13_hv_pmos w=3.6u l=0.9u ng=1
XM12 gd net4 out vp sg13_hv_pmos w=3.6u l=0.9u ng=1 m=8
XM24 vp net5 out gd sg13_hv_nmos w=1.2u l=0.9u ng=1 m=8
XM26 net5 bias4 vp vp sg13_hv_pmos w=3.6u l=0.9u ng=1 m=2
XM28 net4 net1 gd gd sg13_hv_nmos w=1.2u l=0.9u ng=1 m=2
XM25 net5 net5 net4 gd sg13_hv_nmos w=1.2u l=0.9u ng=1 m=2
.ends

* expanding   symbol:  /foss/designs/test/circuit/const_gm_bias_core.sym # of pins=6
** sym_path: /foss/designs/test/circuit/const_gm_bias_core.sym
** sch_path: /foss/designs/test/circuit/const_gm_bias_core.sch
.subckt const_gm_bias_core vp ibias gd res pbias nbias
*.ipin vp
*.ipin gd
*.opin ibias
*.opin res
*.opin nbias
*.opin pbias
XM1 nbias nbias gd gd sg13_hv_nmos w=0.6u l=4u ng=1 m=2
XM2 pbias nbias res gd sg13_hv_nmos w=0.6u l=4u ng=1 m=4
XM4 pbias pbias vp vp sg13_hv_pmos w=0.6u l=4u ng=1 m=2
XM3 nbias pbias vp vp sg13_hv_pmos w=0.6u l=4u ng=1 m=2
XM5 ibias pbias vp vp sg13_hv_pmos w=0.6u l=4u ng=1
XM8 net1 gd vp vp sg13_hv_pmos w=0.6u l=4.38u ng=1
XM6 stup nbias gd gd sg13_hv_nmos w=0.6u l=2u ng=1 m=4
XM9 pbias stup gd gd sg13_hv_nmos w=0.6u l=2u ng=1 m=2
XM7 stup gd net1 vp sg13_hv_pmos w=0.6u l=4.38u ng=1
XM10 vp vp vp vp sg13_hv_pmos w=0.6u l=2u ng=1 m=2
XM11 vp vp vp vp sg13_hv_pmos w=0.6u l=4u ng=1
.ends

.GLOBAL sub!
.end
