** sch_path: /foss/designs/test/testbench/opamp_dc_tb.sch
**.subckt opamp_dc_tb
EINP inp net1 in gd 0.5
EINM inm net1 in gd -0.5
C1 out gd xcload
VGD gd 0 0
VP vp gd xvp
VSUB gd sub! 0
VIN in gd DC xvid
VCM net1 gd '0.7'
Vibias bias net2 0
.save i(vibias)
x2 vp net2 gd net3 net4 const_gm_bias
* noconn #net3
* noconn #net4
x1 vp inp inm out bias gd opamp_folded_pmos
**** begin user architecture code

.lib cornerMOShv.lib mos_tt
.lib cornerRES.lib res_typ

.param xvp=3.3
.param xvid=0
.param xcload=1p

.param xtemp=25

.save v(in)
.save v(out)
.save i(vibias)
.save v(vp)

.temp 'xtemp'
.dc VIN -10m 10m 100u

.option rshunt=1e12

**** end user architecture code
**.ends

* expanding   symbol:  /foss/designs/test/circuit/const_gm_bias.sym # of pins=5
** sym_path: /foss/designs/test/circuit/const_gm_bias.sym
** sch_path: /foss/designs/test/circuit/const_gm_bias.sch
.subckt const_gm_bias vp ibias gd pbias nbias
*.opin ibias
*.ipin vp
*.ipin gd
*.opin pbias
*.opin nbias
xgm_core vp ibias gd vr pbias nbias const_gm_bias_core
XRbias vr gd gd rppd w=1.2e-6 l=11.7e-6 m=1 b=0
XR2 gd net1 gd rppd w=1.2e-6 l=3.9e-6 m=1 b=0
XR3 net1 gd gd rppd w=1.2e-6 l=1.3e-6 m=1 b=0
.ends

* expanding   symbol:  /foss/designs/test/circuit/opamp_folded_pmos.sym # of pins=6
** sym_path: /foss/designs/test/circuit/opamp_folded_pmos.sym
** sch_path: /foss/designs/test/circuit/opamp_folded_pmos.sch
.subckt opamp_folded_pmos vp inp inm out ibias gd
*.ipin ibias
*.ipin inp
*.ipin inm
*.opin out
*.ipin gd
*.ipin vp
XM21 bias4 ibias gd gd sg13_hv_nmos w=1.2u l=0.9u ng=1 m=2
XM22 ibias ibias gd gd sg13_hv_nmos w=1.2u l=0.9u ng=1 m=2
XM23 bias4 bias4 vp vp sg13_hv_pmos w=3.6u l=0.9u ng=1 m=2
XM24 pair_com bias4 vp vp sg13_hv_pmos w=3.6u l=0.9u ng=1 m=4
XM25 inp_folded inp pair_com vp sg13_hv_pmos w=2.4u l=0.9u ng=1 m=10
XM26 inm_folded inm pair_com vp sg13_hv_pmos w=2.4u l=0.9u ng=1 m=10
XM27 net1 tele_g vp vp sg13_hv_pmos w=3.6u l=0.9u ng=1 m=2
XM28 net2 tele_g vp vp sg13_hv_pmos w=3.6u l=0.9u ng=1 m=2
XM29 tele_g bias3 net1 vp sg13_hv_pmos w=3.6u l=0.9u ng=1 m=2
XM30 out bias3 net2 vp sg13_hv_pmos w=3.6u l=0.9u ng=1 m=2
XM31 inp_folded ibias gd gd sg13_hv_nmos w=1.2u l=0.9u ng=1 m=4
XM32 inm_folded ibias gd gd sg13_hv_nmos w=1.2u l=0.9u ng=1 m=4
XM33 tele_g bias2 inp_folded gd sg13_hv_nmos w=1.2u l=0.9u ng=1 m=2
XM34 out bias2 inm_folded gd sg13_hv_nmos w=1.2u l=0.9u ng=1 m=2
XM35 bias3 ibias gd gd sg13_hv_nmos w=1.2u l=0.9u ng=1 m=4
XM36 bias3 bias3 net3 vp sg13_hv_pmos w=3.6u l=0.9u ng=1
XM37 net3 bias3 vp vp sg13_hv_pmos w=3.6u l=0.9u ng=1
XM38 bias2 bias4 vp vp sg13_hv_pmos w=3.6u l=0.9u ng=1 m=4
XM39 net4 bias2 gd gd sg13_hv_nmos w=1.2u l=0.9u ng=1
XM40 bias2 bias2 net4 gd sg13_hv_nmos w=1.2u l=0.9u ng=1
.ends

* expanding   symbol:  /foss/designs/test/circuit/const_gm_bias_core.sym # of pins=6
** sym_path: /foss/designs/test/circuit/const_gm_bias_core.sym
** sch_path: /foss/designs/test/circuit/const_gm_bias_core.sch
.subckt const_gm_bias_core vp ibias gd res pbias nbias
*.ipin vp
*.ipin gd
*.opin ibias
*.opin res
*.opin nbias
*.opin pbias
XM1 net1 nbias gd gd sg13_hv_nmos w=0.6u l=2u ng=1 m=2
XM3 net2 nbias res gd sg13_hv_nmos w=0.6u l=2u ng=1 m=4
XM8 net5 pbias vp vp sg13_hv_pmos w=0.6u l=2u ng=1 m=2
XM6 net4 pbias vp vp sg13_hv_pmos w=0.6u l=2u ng=1 m=2
XM12 net3 pbias vp vp sg13_hv_pmos w=0.6u l=2u ng=1
XM15 net6 gd vp vp sg13_hv_pmos w=0.6u l=4.38u ng=1
XM13 stup nbias gd gd sg13_hv_nmos w=0.6u l=2u ng=1 m=4
XM16 pbias stup gd gd sg13_hv_nmos w=0.6u l=2u ng=1 m=2
XM2 nbias nbias net1 gd sg13_hv_nmos w=0.6u l=2u ng=1 m=2
XM4 pbias nbias net2 gd sg13_hv_nmos w=0.6u l=2u ng=1 m=4
XM11 net8 pbias net3 vp sg13_hv_pmos w=0.6u l=2u ng=1
XM7 pbias pbias net5 vp sg13_hv_pmos w=0.6u l=2u ng=1 m=2
XM5 nbias pbias net4 vp sg13_hv_pmos w=0.6u l=2u ng=1 m=2
XM14 stup gd net6 vp sg13_hv_pmos w=0.6u l=4.38u ng=1
XM10 net7 pbias net8 vp sg13_hv_pmos w=0.6u l=2u ng=1
XM9 ibias pbias net7 vp sg13_hv_pmos w=0.6u l=2u ng=1
.ends

.GLOBAL sub!
.end
