** sch_path: /foss/designs/test/testbench/const_gm_bias_temp_sweep_tb.sch
**.subckt const_gm_bias_temp_sweep_tb
x1 vp out gd pbias nbias const_gm_bias
VP vp gd 'xvp'
.save i(vp)
VP1 gd 0 'xvp'
VP2 gd sub! 'xvp'
VIBIAS out gd 0
.save i(vibias)
C1 nbias gd 1p
C2 pbias gd 1p
**** begin user architecture code

.LIB cornerMOShv.lib mos_tt
.LIB cornerRES.lib res_typ
.LIB cornerPNP.lib typ

.SAVE i(vibias)
.SAVE i(vp)
.param xvp=3.3
.param xtemp=25

.temp 'xtemp'

.global sub!

.dc temp -55 125 0.1

**** end user architecture code
**.ends

* expanding   symbol:  /foss/designs/test/circuit/const_gm_bias.sym # of pins=5
** sym_path: /foss/designs/test/circuit/const_gm_bias.sym
** sch_path: /foss/designs/test/circuit/const_gm_bias.sch
.subckt const_gm_bias vp ibias gd pbias nbias
*.opin ibias
*.ipin vp
*.ipin gd
*.opin pbias
*.opin nbias
xgm_core vp ibias gd vr pbias nbias const_gm_bias_core
XRbias vr gd gd rppd w=1.2e-6 l=11.7e-6 m=1 b=0
XR2 gd net1 gd rppd w=1.2e-6 l=3.9e-6 m=1 b=0
XR3 net1 gd gd rppd w=1.2e-6 l=1.3e-6 m=1 b=0
.ends

* expanding   symbol:  /foss/designs/test/circuit/const_gm_bias_core.sym # of pins=6
** sym_path: /foss/designs/test/circuit/const_gm_bias_core.sym
** sch_path: /foss/designs/test/circuit/const_gm_bias_core.sch
.subckt const_gm_bias_core vp ibias gd res pbias nbias
*.ipin vp
*.ipin gd
*.opin ibias
*.opin res
*.opin nbias
*.opin pbias
XM1 nbias nbias gd gd sg13_hv_nmos w=0.6u l=4u ng=1 m=2
XM2 pbias nbias res gd sg13_hv_nmos w=0.6u l=4u ng=1 m=4
XM4 pbias pbias vp vp sg13_hv_pmos w=0.6u l=4u ng=1 m=2
XM3 nbias pbias vp vp sg13_hv_pmos w=0.6u l=4u ng=1 m=2
XM5 ibias pbias vp vp sg13_hv_pmos w=0.6u l=4u ng=1
XM8 net1 gd vp vp sg13_hv_pmos w=0.6u l=4.38u ng=1
XM6 stup nbias gd gd sg13_hv_nmos w=0.6u l=2u ng=1 m=4
XM9 pbias stup gd gd sg13_hv_nmos w=0.6u l=2u ng=1 m=2
XM7 stup gd net1 vp sg13_hv_pmos w=0.6u l=4.38u ng=1
.ends

.end
