** sch_path: /foss/designs/test/testbench/const_gm_bias_temp_sweep_tb.sch
**.subckt const_gm_bias_temp_sweep_tb
x1 vp out gd const_gm_bias
VP vp gd 'xvp'
.save i(vp)
VP1 gd 0 'xvp'
VP2 gd sub! 'xvp'
VIBIAS out gd 0
.save i(vibias)
**** begin user architecture code

.LIB cornerMOShv.lib mos_tt
.LIB cornerRES.lib res_typ
.LIB cornerPNP.lib typ

.SAVE i(vibias)
.SAVE i(vp)
.param xvp=3.3
.param xtemp=25

.temp 'xtemp'

.global sub!

.dc temp -55 125 0.1

**** end user architecture code
**.ends

* expanding   symbol:  /foss/designs/test/circuit/const_gm_bias.sym # of pins=3
** sym_path: /foss/designs/test/circuit/const_gm_bias.sym
** sch_path: /foss/designs/test/circuit/const_gm_bias.sch
.subckt const_gm_bias vp ibias gd
*.opin ibias
*.ipin vp
*.ipin gd
xgm_core vp ibias gd vr const_gm_bias_core
XRbias vr gd gd rppd w=1.2e-6 l=11.7e-6 m=1 b=0
XR2 gd net1 gd rppd w=1.2e-6 l=3.9e-6 m=1 b=0
XR3 net1 gd gd rppd w=1.2e-6 l=1.3e-6 m=1 b=0
.ends

* expanding   symbol:  /foss/designs/test/circuit/const_gm_bias_core.sym # of pins=4
** sym_path: /foss/designs/test/circuit/const_gm_bias_core.sym
** sch_path: /foss/designs/test/circuit/const_gm_bias_core.sch
.subckt const_gm_bias_core vp ibias gd res
*.ipin vp
*.ipin gd
*.opin ibias
*.opin res
XM1 net1 nbias gd gd sg13_hv_nmos w=0.6u l=2u ng=1 m=2
XM3 net2 nbias res gd sg13_hv_nmos w=0.6u l=2u ng=1 m=4
XM8 net5 pbias vp vp sg13_hv_pmos w=0.6u l=2u ng=1 m=2
XM6 net4 pbias vp vp sg13_hv_pmos w=0.6u l=2u ng=1 m=2
XM12 net3 pbias vp vp sg13_hv_pmos w=0.6u l=2u ng=1
XM15 net6 gd vp vp sg13_hv_pmos w=0.6u l=4.38u ng=1
XM13 stup nbias gd gd sg13_hv_nmos w=0.6u l=2u ng=1 m=4
XM16 pbias stup gd gd sg13_hv_nmos w=0.6u l=2u ng=1 m=2
XM2 nbias nbias net1 gd sg13_hv_nmos w=0.6u l=2u ng=1 m=2
XM4 pbias nbias net2 gd sg13_hv_nmos w=0.6u l=2u ng=1 m=4
XM11 net8 pbias net3 vp sg13_hv_pmos w=0.6u l=2u ng=1
XM7 pbias pbias net5 vp sg13_hv_pmos w=0.6u l=2u ng=1 m=2
XM5 nbias pbias net4 vp sg13_hv_pmos w=0.6u l=2u ng=1 m=2
XM14 stup gd net6 vp sg13_hv_pmos w=0.6u l=4.38u ng=1
XM10 net7 pbias net8 vp sg13_hv_pmos w=0.6u l=2u ng=1
XM9 ibias pbias net7 vp sg13_hv_pmos w=0.6u l=2u ng=1
.ends

.end
