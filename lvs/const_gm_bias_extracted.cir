* Extracted by KLayout with SG13CMOS5L LVS runset on : 06/06/2026 20:00

.SUBCKT const_gm_bias gd ibias vp
M$1 gd \$40 \$41 gd sg13_hv_nmos L=2u W=0.6u AS=0.204p AD=0.204p PS=1.88u
+ PD=1.88u rfmode=0
M$2 \$39 \$40 \$42 gd sg13_hv_nmos L=2u W=2.4u AS=0.816p AD=0.816p PS=7.52u
+ PD=7.52u rfmode=0
M$6 \$48 \$40 \$42 gd sg13_hv_nmos L=2u W=2.4u AS=0.816p AD=0.816p PS=7.52u
+ PD=7.52u rfmode=0
M$7 \$40 \$40 \$41 gd sg13_hv_nmos L=2u W=0.6u AS=0.204p AD=0.204p PS=1.88u
+ PD=1.88u rfmode=0
M$11 \$40 \$48 \$55 vp sg13_hv_pmos L=2u W=0.6u AS=0.204p AD=0.204p PS=1.88u
+ PD=1.88u rfmode=0
M$12 \$48 \$48 \$56 vp sg13_hv_pmos L=2u W=0.6u AS=0.204p AD=0.204p PS=1.88u
+ PD=1.88u rfmode=0
M$13 ibias \$48 \$57 vp sg13_hv_pmos L=2u W=0.6u AS=0.204p AD=0.204p PS=1.88u
+ PD=1.88u rfmode=0
M$14 vp \$48 vp vp sg13_hv_pmos L=2u W=2.4u AS=0.816p AD=0.816p PS=7.52u
+ PD=7.52u rfmode=0
M$16 vp \$48 \$55 vp sg13_hv_pmos L=2u W=0.6u AS=0.204p AD=0.204p PS=1.88u
+ PD=1.88u rfmode=0
M$17 vp \$48 \$56 vp sg13_hv_pmos L=2u W=0.6u AS=0.204p AD=0.204p PS=1.88u
+ PD=1.88u rfmode=0
M$18 vp \$48 \$57 vp sg13_hv_pmos L=2u W=0.6u AS=0.204p AD=0.204p PS=1.88u
+ PD=1.88u rfmode=0
R$38 \$39 gd gd rppd w=0.5u l=57u ps=0u b=0 m=1
.ENDS const_gm_bias
